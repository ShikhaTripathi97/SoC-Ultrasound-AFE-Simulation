** Profile: "SCHEMATIC1-transmitamp_sim"  [ c:\users\shikh\appdata\roaming\spb_data\cdssetup\workspace\projects\transmitter\transmitter-pspicefiles\schematic1\transmitamp_sim.sim ]

** Creating circuit file "transmitamp_sim.cir"
** WARNING: THIS AUTOMATICALLY GENERATED FILE MAY BE OVERWRITTEN BY SUBSEQUENT SIMULATIONS

*Libraries:
* Profile Libraries :
* Local Libraries :
.LIB "C:/Users/shikh/Downloads/ADA4870.cir"
* From [PSPICE NETLIST] section of C:\Users\shikh\AppData\Roaming\SPB_Data\cdssetup\OrCAD_PSpice\24.1.0\PSpice.ini file:
.lib "nom.lib"

*Analysis directives:
.TRAN  0 1000ns 0
.OPTIONS ADVCONV
.PROBE64 V(alias(*)) I(alias(*)) W(alias(*)) D(alias(*)) NOISE(alias(*))
.INC "..\SCHEMATIC1.net"

.END
