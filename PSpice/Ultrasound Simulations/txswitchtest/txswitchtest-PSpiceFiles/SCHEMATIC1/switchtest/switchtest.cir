** Profile: "SCHEMATIC1-switchtest"  [ c:\users\shikh\appdata\roaming\spb_data\cdssetup\workspace\projects\txswitchtest\txswitchtest-PSpiceFiles\SCHEMATIC1\switchtest.sim ]

** Creating circuit file "switchtest.cir"
** WARNING: THIS AUTOMATICALLY GENERATED FILE MAY BE OVERWRITTEN BY SUBSEQUENT SIMULATIONS

*Libraries:
* Profile Libraries :
* Local Libraries :
.LIB "C:/Users/shikh/Downloads/ADA4870.cir"
.LIB "C:/Cadence/OrCADX_24.1/tools/capture/library/pspice/TX810_PSPICE_AIO/TX810.lib"
* From [PSPICE NETLIST] section of C:\Users\shikh\AppData\Roaming\SPB_Data\cdssetup\OrCAD_PSpice\24.1.0\PSpice.ini file:
.lib "nom.lib"

*Analysis directives:
.TRAN  0 1000ns  0 10n SKIPBP
.OPTIONS ADVCONV
.OPTIONS PTRANABSTOL= 1e-5
.OPTIONS PTRANVNTOL= 1e-4
.AUTOCONVERGE ITL1=1000 ITL2=1000 ITL4=1000 RELTOL=0.05 ABSTOL=1.0E-6 VNTOL=.001 PIVTOL=1.0E-10
.PROBE64 V(alias(*)) I(alias(*)) W(alias(*)) D(alias(*)) NOISE(alias(*))
.INC "..\SCHEMATIC1.net"

.END
